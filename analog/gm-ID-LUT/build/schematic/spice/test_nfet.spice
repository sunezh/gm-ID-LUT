** sch_path: /home/sunezh/Analog/Personal-Projects/gm-ID-LUT/analog/gm-ID-LUT/schematics/test_nfet.sch
**.subckt test_nfet
XM1 net2 net1 GND GND sky130_fd_pr__nfet_01v8 L=0.15 W=1 nf=1 ad='int((nf+1)/2) * W/nf * 0.29' as='int((nf+2)/2) * W/nf * 0.29' pd='2*int((nf+1)/2) * (W/nf + 0.29)'
+ ps='2*int((nf+2)/2) * (W/nf + 0.29)' nrd='0.29 / W' nrs='0.29 / W' sa=0 sb=0 sd=0 mult=1 m=1
VDS net2 GND 1
VGS net1 GND 0.8
**** begin user architecture code

.param mc_mm_switch=0
.param mc_pr_switch=0
.include /home/sunezh/.volare/sky130A/libs.tech/ngspice/corners/tt.spice
.include /home/sunezh/.volare/sky130A/libs.tech/ngspice/r+c/res_typical__cap_typical.spice
.include /home/sunezh/.volare/sky130A/libs.tech/ngspice/r+c/res_typical__cap_typical__lin.spice
.include /home/sunezh/.volare/sky130A/libs.tech/ngspice/corners/tt/specialized_cells.spice

.control
op
print @m.xm1.msky130_fd_pr__nfet_01v8[gm]
print @m.xm1.msky130_fd_pr__nfet_01v8[id]
print @m.xm1.msky130_fd_pr__nfet_01v8[vth]
.endc

**** end user architecture code
**.ends
.GLOBAL GND
.end
